* SKY130 mixed-signal analog PLIF primitives (transistors + PDK MIM).
* The restore/mux and direct weight-DAC subcircuits retain old Q7.16-style
* digital interfaces as legacy experiments; that encoding is not the analog
* precision target. The reference is the original float32 model. The leading
* event-source candidate is fixed-width MOS injection with signed weight encoded
* in pulse amplitude. It currently uses ideal gate voltages and has not passed
* physical weight storage/drive, noise/mismatch, temperature or layout gates.
* Pulse-duration encoding was rejected for the measured full-float fan-in because
* its transfer range overshot by 6.7x–33x. Passive packet accumulation and current
* OTA-C alternatives also failed order/PVT gates. No PLIF cell is selected yet.
* Switched-capacitor transfer remains an alternative to investigate, not a chosen
* fallback. No QAT or quantized export defines analog precision.
* Weight scale and membrane voltage mapping are to be measured per actor family.
* No QAT or quantized export is required for the analog reference path.
* Analog state uses the PDK MIM membrane; legacy digital-code restore remains
* separately present pending model-based validation.
* Legacy WDAC injector rails are full range; its 24-bit interface is not approved
* as an analog weight-precision requirement. Current linearity and signed matching
* remain unqualified outside the bounded calibrated full-fan-in experiment.
* Decay ≈ MOS conductance to vcm during an explicit leak phase.
* Beta mapping (declared approx): t_leak ≈ -tau_nom * ln(beta).
* Membrane ≈ PDK MIM; restore via 24-bit R-2R + TG (ideal R provisional).
* Population/state storage and channel service are open feasibility questions;
* no 24-bit logical-membrane representation is selected for the analog design.
.include "sky130_ms_r2r24.spice"

.subckt membrane_mim state vcm params: w_um=100 l_um=100
Xmim state vcm sky130_fd_pr__cap_mim_m3_2 w={w_um} l={l_um} mf=1
.ends membrane_mim

.subckt synapse_mos_inject pulse_pos pulse_neg membrane ibias_p ibias_n vss
Xp membrane pulse_pos ibias_p ibias_p sky130_fd_pr__pfet_01v8 w=1.5 l=0.5
Xn membrane pulse_neg ibias_n vss sky130_fd_pr__nfet_01v8 w=1 l=0.5
.ends synapse_mos_inject

.subckt leak_mos_to_vcm membrane vcm leak_en leak_enb vdd vss
Xn membrane leak_en vcm vss sky130_fd_pr__nfet_01v8 w=0.5 l=8
Xp membrane leak_enb vcm vdd sky130_fd_pr__pfet_01v8 w=1 l=8
.ends leak_mos_to_vcm

* Legacy fixed-bias channel (smoke benches).
.subckt analog_plif_channel state snapshot spike
+ capture capture_b reset reset_b leak_en leak_enb
+ pulse_pos pulse_neg ibias_p ibias_n vbias vdd vss vcm
+ params: theta=0.4 scale=0.2 w_um=100 l_um=100
Xmem state vcm membrane_mim w_um={w_um} l_um={l_um}
Xrst vcm state reset reset_b vdd vss transmission_gate
Xsyn pulse_pos pulse_neg state ibias_p ibias_n vss synapse_mos_inject
Xleak state vcm leak_en leak_enb vdd vss leak_mos_to_vcm
Xsnap state snapshot capture capture_b vdd vss transmission_gate
Csnap_hold snapshot vcm 50f
Bthreshold threshold vss V={v(vcm)+scale*theta}
Xcmp snapshot threshold spike vbias vdd vss comparator
.ends analog_plif_channel

* Channel with signed Q7.16 weight inject (23-bit |w| + sign).
.subckt analog_plif_channel_wdac state snapshot spike
+ capture capture_b reset reset_b leak_en leak_enb
+ pulse_pos pulse_neg sign_n
+ w22 w21 w20 w19 w18 w17 w16 w15 w14 w13 w12 w11 w10 w9 w8 w7 w6 w5 w4 w3 w2 w1 w0
+ vbias weight_hi weight_lo ibias_n_off vdd vss vcm
+ params: theta=0.4 scale=0.2 w_um=100 l_um=100
Xmem state vcm membrane_mim w_um={w_um} l_um={l_um}
Xrst vcm state reset reset_b vdd vss transmission_gate
Xw state pulse_pos pulse_neg sign_n
+ w22 w21 w20 w19 w18 w17 w16 w15 w14 w13 w12 w11 w10 w9 w8 w7 w6 w5 w4 w3 w2 w1 w0
+ weight_hi weight_lo ibias_n_off vdd vss weight_inject_q716
Xleak state vcm leak_en leak_enb vdd vss leak_mos_to_vcm
Xsnap state snapshot capture capture_b vdd vss transmission_gate
Csnap_hold snapshot vcm 50f
Bthreshold threshold vss V={v(vcm)+scale*theta}
Xcmp snapshot threshold spike vbias vdd vss comparator
.ends analog_plif_channel_wdac

* Multiplexed channel: 24-bit Q7.16 membrane restore + Q7.16 weight inject.
.subckt analog_plif_mux_channel state snapshot spike
+ capture capture_b reset reset_b leak_en leak_enb restore restore_b
+ pulse_pos pulse_neg sign_n
+ w22 w21 w20 w19 w18 w17 w16 w15 w14 w13 w12 w11 w10 w9 w8 w7 w6 w5 w4 w3 w2 w1 w0
+ m23 m22 m21 m20 m19 m18 m17 m16 m15 m14 m13 m12 m11 m10 m9 m8 m7 m6 m5 m4 m3 m2 m1 m0
+ vbias mem_hi mem_lo weight_hi weight_lo ibias_n_off vdd vss vcm
+ params: theta=0.4 scale=0.2 w_um=100 l_um=100
Xmem state vcm membrane_mim w_um={w_um} l_um={l_um}
Xrst vcm state reset reset_b vdd vss transmission_gate
Xrestore state restore_dac
+ m23 m22 m21 m20 m19 m18 m17 m16 m15 m14 m13 m12 m11 m10 m9 m8 m7 m6 m5 m4 m3 m2 m1 m0
+ restore restore_b mem_hi mem_lo vdd vss membrane_restore_write_offset_u24
Xw state pulse_pos pulse_neg sign_n
+ w22 w21 w20 w19 w18 w17 w16 w15 w14 w13 w12 w11 w10 w9 w8 w7 w6 w5 w4 w3 w2 w1 w0
+ weight_hi weight_lo ibias_n_off vdd vss weight_inject_q716
Xleak state vcm leak_en leak_enb vdd vss leak_mos_to_vcm
Xsnap state snapshot capture capture_b vdd vss transmission_gate
Csnap_hold snapshot vcm 50f
Bthreshold threshold vss V={v(vcm)+scale*theta}
Xcmp snapshot threshold spike vbias vdd vss comparator
.ends analog_plif_mux_channel

* Rejected diagnostic: analog membrane update with Q7.16 magnitude represented by pulse duration.
* Pulse inputs are gate levels: p_gate=1.0V / n_gate=0.525V during activity,
* p_gate=vdd / n_gate=vss when inactive. Nominal TT sizing matches the bounded
* 1pF charge screen only; calibrate widths, bias and PVT before using at scale.
.subckt synapse_pulse_width_mos state p_gate n_gate vdd vss
Xp_width state p_gate vdd vdd sky130_fd_pr__pfet_01v8 w=1.0 l=2
Xn_width state n_gate vss vss sky130_fd_pr__nfet_01v8 w=0.42 l=2
.ends synapse_pulse_width_mos

* Pulse-width injector calibration wrapper. Xrst is a hard return to VCM and is
* NOT equivalent to the trained float PLIF subtractive reset; it is retained for
* injection/retention characterization only. Use the soft_reset variant below
* for model-semantic reset experiments. p_gate/n_gate represent signed pulses.
.subckt analog_plif_channel_pulse_duration state snapshot spike
+ capture capture_b reset reset_b leak_en leak_enb
+ p_gate n_gate vbias vdd vss vcm
+ params: theta=0.4 scale=0.2 w_um=100 l_um=100
Xmem state vcm membrane_mim w_um={w_um} l_um={l_um}
Xrst vcm state reset reset_b vdd vss transmission_gate
Xw state p_gate n_gate vdd vss synapse_pulse_width_mos
Xleak state vcm leak_en leak_enb vdd vss leak_mos_to_vcm
Xsnap state snapshot capture capture_b vdd vss transmission_gate
Csnap_hold snapshot vcm 50f
Bthreshold threshold vss V={v(vcm)+scale*theta}
Xcmp snapshot threshold spike vbias vdd vss comparator
.ends analog_plif_channel_pulse_duration

* Float PLIF reset candidate: the model uses subtractive (soft) reset, not a
* return-to-VCM reset. initialize is a one-time hard precharge; after a spike,
* the controller sends a calibrated negative threshold-charge pulse on the
* soft_reset gates. This pulse implementation is not yet qualified.
.subckt analog_plif_channel_pulse_duration_soft_reset state snapshot spike
+ capture capture_b initialize initialize_b leak_en leak_enb
+ p_gate n_gate soft_reset_p_gate soft_reset_n_gate vbias vdd vss vcm
+ params: theta=0.4 scale=0.2 w_um=100 l_um=100
Xmem state vcm membrane_mim w_um={w_um} l_um={l_um}
Xinit vcm state initialize initialize_b vdd vss transmission_gate
Xw state p_gate n_gate vdd vss synapse_pulse_width_mos
Xsoft state soft_reset_p_gate soft_reset_n_gate vdd vss synapse_pulse_width_mos
Xleak state vcm leak_en leak_enb vdd vss leak_mos_to_vcm
Xsnap state snapshot capture capture_b vdd vss transmission_gate
Csnap_hold snapshot vcm 50f
Bthreshold threshold vss V={v(vcm)+scale*theta}
Xcmp snapshot threshold spike vbias vdd vss comparator
.ends analog_plif_channel_pulse_duration_soft_reset
