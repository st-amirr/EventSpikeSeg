* Autogenerated by scripts/build_sky130_ms_r2r24.py — do not hand-edit.
* Digital formats (docs/project_spec.yaml quantization.active_formats):
*   weights/membrane/base_threshold: signed_int24_Q7_16
*   beta: unsigned_int24_UQ1_23 (leak phase elsewhere)
* Ideal 1k/2k R provisional pending PDK resistor layout/extraction.
* Large DAC-only switches and low ladder impedance reduce modeled R-2R loading.
* R-2R input is unsigned offset-binary u24; V(out) ~= vlo + (u24/2**24)*(vhi-vlo).
* Do not connect raw two's-complement Q7.16 bits here: map/saturate in the
* digital restore controller for each declared state range and voltage scale.
* Ideal-R schematic only. No resistor matching, switch-Ron, noise, ADC,
* or 24-bit ENOB claim. Digital membrane state remains signed Q7.16.

.subckt r2r_inv a y vdd vss
Xpd y a vdd vdd sky130_fd_pr__pfet_01v8 w=2 l=0.15 m=50
Xnd y a vss vss sky130_fd_pr__nfet_01v8 w=1 l=0.15 m=50
.ends r2r_inv
.subckt r2r_switch a b en enb vdd vss
Xn a en b vss sky130_fd_pr__nfet_01v8 w=1 l=0.15 m=100
Xp a enb b vdd sky130_fd_pr__pfet_01v8 w=2 l=0.15 m=100
.ends r2r_switch

.subckt r2r_dac_u24 out
+ b23 b22 b21 b20 b19 b18 b17 b16 b15 b14 b13 b12 b11 b10 b9 b8 b7 b6 b5 b4 b3 b2 b1 b0
+ vhi vlo vdd vss
Xiv0 b0 bb0 vdd vss r2r_inv
Xiv1 b1 bb1 vdd vss r2r_inv
Xiv2 b2 bb2 vdd vss r2r_inv
Xiv3 b3 bb3 vdd vss r2r_inv
Xiv4 b4 bb4 vdd vss r2r_inv
Xiv5 b5 bb5 vdd vss r2r_inv
Xiv6 b6 bb6 vdd vss r2r_inv
Xiv7 b7 bb7 vdd vss r2r_inv
Xiv8 b8 bb8 vdd vss r2r_inv
Xiv9 b9 bb9 vdd vss r2r_inv
Xiv10 b10 bb10 vdd vss r2r_inv
Xiv11 b11 bb11 vdd vss r2r_inv
Xiv12 b12 bb12 vdd vss r2r_inv
Xiv13 b13 bb13 vdd vss r2r_inv
Xiv14 b14 bb14 vdd vss r2r_inv
Xiv15 b15 bb15 vdd vss r2r_inv
Xiv16 b16 bb16 vdd vss r2r_inv
Xiv17 b17 bb17 vdd vss r2r_inv
Xiv18 b18 bb18 vdd vss r2r_inv
Xiv19 b19 bb19 vdd vss r2r_inv
Xiv20 b20 bb20 vdd vss r2r_inv
Xiv21 b21 bb21 vdd vss r2r_inv
Xiv22 b22 bb22 vdd vss r2r_inv
Xiv23 b23 bb23 vdd vss r2r_inv
Rterm n0 vlo 2000
Rq23 out n22 1000
Rq22 n22 n21 1000
Rq21 n21 n20 1000
Rq20 n20 n19 1000
Rq19 n19 n18 1000
Rq18 n18 n17 1000
Rq17 n17 n16 1000
Rq16 n16 n15 1000
Rq15 n15 n14 1000
Rq14 n14 n13 1000
Rq13 n13 n12 1000
Rq12 n12 n11 1000
Rq11 n11 n10 1000
Rq10 n10 n9 1000
Rq9 n9 n8 1000
Rq8 n8 n7 1000
Rq7 n7 n6 1000
Rq6 n6 n5 1000
Rq5 n5 n4 1000
Rq4 n4 n3 1000
Rq3 n3 n2 1000
Rq2 n2 n1 1000
Rq1 n1 n0 1000
R2b23 out m23 2000
Xth23 vhi m23 b23 bb23 vdd vss r2r_switch
Xtl23 vlo m23 bb23 b23 vdd vss r2r_switch
R2b22 n22 m22 2000
Xth22 vhi m22 b22 bb22 vdd vss r2r_switch
Xtl22 vlo m22 bb22 b22 vdd vss r2r_switch
R2b21 n21 m21 2000
Xth21 vhi m21 b21 bb21 vdd vss r2r_switch
Xtl21 vlo m21 bb21 b21 vdd vss r2r_switch
R2b20 n20 m20 2000
Xth20 vhi m20 b20 bb20 vdd vss r2r_switch
Xtl20 vlo m20 bb20 b20 vdd vss r2r_switch
R2b19 n19 m19 2000
Xth19 vhi m19 b19 bb19 vdd vss r2r_switch
Xtl19 vlo m19 bb19 b19 vdd vss r2r_switch
R2b18 n18 m18 2000
Xth18 vhi m18 b18 bb18 vdd vss r2r_switch
Xtl18 vlo m18 bb18 b18 vdd vss r2r_switch
R2b17 n17 m17 2000
Xth17 vhi m17 b17 bb17 vdd vss r2r_switch
Xtl17 vlo m17 bb17 b17 vdd vss r2r_switch
R2b16 n16 m16 2000
Xth16 vhi m16 b16 bb16 vdd vss r2r_switch
Xtl16 vlo m16 bb16 b16 vdd vss r2r_switch
R2b15 n15 m15 2000
Xth15 vhi m15 b15 bb15 vdd vss r2r_switch
Xtl15 vlo m15 bb15 b15 vdd vss r2r_switch
R2b14 n14 m14 2000
Xth14 vhi m14 b14 bb14 vdd vss r2r_switch
Xtl14 vlo m14 bb14 b14 vdd vss r2r_switch
R2b13 n13 m13 2000
Xth13 vhi m13 b13 bb13 vdd vss r2r_switch
Xtl13 vlo m13 bb13 b13 vdd vss r2r_switch
R2b12 n12 m12 2000
Xth12 vhi m12 b12 bb12 vdd vss r2r_switch
Xtl12 vlo m12 bb12 b12 vdd vss r2r_switch
R2b11 n11 m11 2000
Xth11 vhi m11 b11 bb11 vdd vss r2r_switch
Xtl11 vlo m11 bb11 b11 vdd vss r2r_switch
R2b10 n10 m10 2000
Xth10 vhi m10 b10 bb10 vdd vss r2r_switch
Xtl10 vlo m10 bb10 b10 vdd vss r2r_switch
R2b9 n9 m9 2000
Xth9 vhi m9 b9 bb9 vdd vss r2r_switch
Xtl9 vlo m9 bb9 b9 vdd vss r2r_switch
R2b8 n8 m8 2000
Xth8 vhi m8 b8 bb8 vdd vss r2r_switch
Xtl8 vlo m8 bb8 b8 vdd vss r2r_switch
R2b7 n7 m7 2000
Xth7 vhi m7 b7 bb7 vdd vss r2r_switch
Xtl7 vlo m7 bb7 b7 vdd vss r2r_switch
R2b6 n6 m6 2000
Xth6 vhi m6 b6 bb6 vdd vss r2r_switch
Xtl6 vlo m6 bb6 b6 vdd vss r2r_switch
R2b5 n5 m5 2000
Xth5 vhi m5 b5 bb5 vdd vss r2r_switch
Xtl5 vlo m5 bb5 b5 vdd vss r2r_switch
R2b4 n4 m4 2000
Xth4 vhi m4 b4 bb4 vdd vss r2r_switch
Xtl4 vlo m4 bb4 b4 vdd vss r2r_switch
R2b3 n3 m3 2000
Xth3 vhi m3 b3 bb3 vdd vss r2r_switch
Xtl3 vlo m3 bb3 b3 vdd vss r2r_switch
R2b2 n2 m2 2000
Xth2 vhi m2 b2 bb2 vdd vss r2r_switch
Xtl2 vlo m2 bb2 b2 vdd vss r2r_switch
R2b1 n1 m1 2000
Xth1 vhi m1 b1 bb1 vdd vss r2r_switch
Xtl1 vlo m1 bb1 b1 vdd vss r2r_switch
R2b0 n0 m0 2000
Xth0 vhi m0 b0 bb0 vdd vss r2r_switch
Xtl0 vlo m0 bb0 b0 vdd vss r2r_switch
.ends r2r_dac_u24

.subckt membrane_code_vdac_offset_u24 out
+ b23 b22 b21 b20 b19 b18 b17 b16 b15 b14 b13 b12 b11 b10 b9 b8 b7 b6 b5 b4 b3 b2 b1 b0
+ vhi vlo vdd vss
Xdac out b23 b22 b21 b20 b19 b18 b17 b16 b15 b14 b13 b12 b11 b10 b9 b8 b7 b6 b5 b4 b3 b2 b1 b0 vhi vlo vdd vss r2r_dac_u24
.ends membrane_code_vdac_offset_u24

.subckt membrane_restore_write_offset_u24 state vdac
+ b23 b22 b21 b20 b19 b18 b17 b16 b15 b14 b13 b12 b11 b10 b9 b8 b7 b6 b5 b4 b3 b2 b1 b0
+ restore restore_b
+ vhi vlo vdd vss
Xdac vdac b23 b22 b21 b20 b19 b18 b17 b16 b15 b14 b13 b12 b11 b10 b9 b8 b7 b6 b5 b4 b3 b2 b1 b0 vhi vlo vdd vss membrane_code_vdac_offset_u24
Xwr vdac state restore restore_b vdd vss transmission_gate
.ends membrane_restore_write_offset_u24

* |weight| unsigned u23 aligned to the top 23 R-2R bits; b0=0.
.subckt weight_mag_vdac_u23 vw
+ w22 w21 w20 w19 w18 w17 w16 w15 w14 w13 w12 w11 w10 w9 w8 w7 w6 w5 w4 w3 w2 w1 w0
+ vhi vlo vdd vss
Vb0_tie b0 0 0
Xdac vw w22 w21 w20 w19 w18 w17 w16 w15 w14 w13 w12 w11 w10 w9 w8 w7 w6 w5 w4 w3 w2 w1 w0 b0 vhi vlo vdd vss r2r_dac_u24
.ends weight_mag_vdac_u23

.subckt and2 a b y vdd vss
Xnand a b yb vdd vss nand2
Xinv yb y vdd vss inv
.ends and2
.subckt nand2 a b y vdd vss
Xp1 y a vdd vdd sky130_fd_pr__pfet_01v8 w=2 l=0.15
Xp2 y b vdd vdd sky130_fd_pr__pfet_01v8 w=2 l=0.15
Xn1 y a n vss sky130_fd_pr__nfet_01v8 w=1 l=0.15
Xn2 n b vss vss sky130_fd_pr__nfet_01v8 w=1 l=0.15
.ends nand2

* One magnitude DAC; sign selects normal/complement bits at high-impedance switch controls.
.subckt weight_gate_vdac_u23 vw
+ w22 w21 w20 w19 w18 w17 w16 w15 w14 w13 w12 w11 w10 w9 w8 w7 w6 w5 w4 w3 w2 w1 w0
+ sign_n vhi vlo vdd vss
Xsign_inv sign_n sign_p vdd vss inv
Xwg_inv0 w0 wn0 vdd vss inv
Xwg_pos0 wn0 b1 sign_p sign_n vdd vss transmission_gate
Xwg_neg0 w0 b1 sign_n sign_p vdd vss transmission_gate
Xwg_inv1 w1 wn1 vdd vss inv
Xwg_pos1 wn1 b2 sign_p sign_n vdd vss transmission_gate
Xwg_neg1 w1 b2 sign_n sign_p vdd vss transmission_gate
Xwg_inv2 w2 wn2 vdd vss inv
Xwg_pos2 wn2 b3 sign_p sign_n vdd vss transmission_gate
Xwg_neg2 w2 b3 sign_n sign_p vdd vss transmission_gate
Xwg_inv3 w3 wn3 vdd vss inv
Xwg_pos3 wn3 b4 sign_p sign_n vdd vss transmission_gate
Xwg_neg3 w3 b4 sign_n sign_p vdd vss transmission_gate
Xwg_inv4 w4 wn4 vdd vss inv
Xwg_pos4 wn4 b5 sign_p sign_n vdd vss transmission_gate
Xwg_neg4 w4 b5 sign_n sign_p vdd vss transmission_gate
Xwg_inv5 w5 wn5 vdd vss inv
Xwg_pos5 wn5 b6 sign_p sign_n vdd vss transmission_gate
Xwg_neg5 w5 b6 sign_n sign_p vdd vss transmission_gate
Xwg_inv6 w6 wn6 vdd vss inv
Xwg_pos6 wn6 b7 sign_p sign_n vdd vss transmission_gate
Xwg_neg6 w6 b7 sign_n sign_p vdd vss transmission_gate
Xwg_inv7 w7 wn7 vdd vss inv
Xwg_pos7 wn7 b8 sign_p sign_n vdd vss transmission_gate
Xwg_neg7 w7 b8 sign_n sign_p vdd vss transmission_gate
Xwg_inv8 w8 wn8 vdd vss inv
Xwg_pos8 wn8 b9 sign_p sign_n vdd vss transmission_gate
Xwg_neg8 w8 b9 sign_n sign_p vdd vss transmission_gate
Xwg_inv9 w9 wn9 vdd vss inv
Xwg_pos9 wn9 b10 sign_p sign_n vdd vss transmission_gate
Xwg_neg9 w9 b10 sign_n sign_p vdd vss transmission_gate
Xwg_inv10 w10 wn10 vdd vss inv
Xwg_pos10 wn10 b11 sign_p sign_n vdd vss transmission_gate
Xwg_neg10 w10 b11 sign_n sign_p vdd vss transmission_gate
Xwg_inv11 w11 wn11 vdd vss inv
Xwg_pos11 wn11 b12 sign_p sign_n vdd vss transmission_gate
Xwg_neg11 w11 b12 sign_n sign_p vdd vss transmission_gate
Xwg_inv12 w12 wn12 vdd vss inv
Xwg_pos12 wn12 b13 sign_p sign_n vdd vss transmission_gate
Xwg_neg12 w12 b13 sign_n sign_p vdd vss transmission_gate
Xwg_inv13 w13 wn13 vdd vss inv
Xwg_pos13 wn13 b14 sign_p sign_n vdd vss transmission_gate
Xwg_neg13 w13 b14 sign_n sign_p vdd vss transmission_gate
Xwg_inv14 w14 wn14 vdd vss inv
Xwg_pos14 wn14 b15 sign_p sign_n vdd vss transmission_gate
Xwg_neg14 w14 b15 sign_n sign_p vdd vss transmission_gate
Xwg_inv15 w15 wn15 vdd vss inv
Xwg_pos15 wn15 b16 sign_p sign_n vdd vss transmission_gate
Xwg_neg15 w15 b16 sign_n sign_p vdd vss transmission_gate
Xwg_inv16 w16 wn16 vdd vss inv
Xwg_pos16 wn16 b17 sign_p sign_n vdd vss transmission_gate
Xwg_neg16 w16 b17 sign_n sign_p vdd vss transmission_gate
Xwg_inv17 w17 wn17 vdd vss inv
Xwg_pos17 wn17 b18 sign_p sign_n vdd vss transmission_gate
Xwg_neg17 w17 b18 sign_n sign_p vdd vss transmission_gate
Xwg_inv18 w18 wn18 vdd vss inv
Xwg_pos18 wn18 b19 sign_p sign_n vdd vss transmission_gate
Xwg_neg18 w18 b19 sign_n sign_p vdd vss transmission_gate
Xwg_inv19 w19 wn19 vdd vss inv
Xwg_pos19 wn19 b20 sign_p sign_n vdd vss transmission_gate
Xwg_neg19 w19 b20 sign_n sign_p vdd vss transmission_gate
Xwg_inv20 w20 wn20 vdd vss inv
Xwg_pos20 wn20 b21 sign_p sign_n vdd vss transmission_gate
Xwg_neg20 w20 b21 sign_n sign_p vdd vss transmission_gate
Xwg_inv21 w21 wn21 vdd vss inv
Xwg_pos21 wn21 b22 sign_p sign_n vdd vss transmission_gate
Xwg_neg21 w21 b22 sign_n sign_p vdd vss transmission_gate
Xwg_inv22 w22 wn22 vdd vss inv
Xwg_pos22 wn22 b23 sign_p sign_n vdd vss transmission_gate
Xwg_neg22 w22 b23 sign_n sign_p vdd vss transmission_gate
Xdac vw b23 b22 b21 b20 b19 b18 b17 b16 b15 b14 b13 b12 b11 b10 b9 b8 b7 b6 b5 b4 b3 b2 b1 sign_p vhi vlo vdd vss r2r_dac_u24
.ends weight_gate_vdac_u23

* PMOS current source is fixed at vdd; NMOS current sink is fixed at vss.
* Separate sign-qualified pulse switches connect only the selected path.
* w22..w0 are calibrated unsigned gate codes, not raw signed Q7.16 bits.
* The source Q7.16 weight must remain in digital storage; TT calibration is provisional.
* pulse_pos is active-LOW (PMOS); pulse_neg is active-HIGH (NMOS).
.subckt weight_inject_q716 membrane
+ pulse_pos pulse_neg sign_n
+ w22 w21 w20 w19 w18 w17 w16 w15 w14 w13 w12 w11 w10 w9 w8 w7 w6 w5 w4 w3 w2 w1 w0
+ vhi vlo ibias_n_off vdd vss
Xwg vw
+ w22 w21 w20 w19 w18 w17 w16 w15 w14 w13 w12 w11 w10 w9 w8 w7 w6 w5 w4 w3 w2 w1 w0 sign_n vhi vlo vdd vss weight_gate_vdac_u23
* P-current source width was tuned from the bounded integrated TT transfer screen.
Xp_bias psrc vw vdd vdd sky130_fd_pr__pfet_01v8 w=11.3 l=2
Xn_bias nsrc vw vss vss sky130_fd_pr__nfet_01v8 w=2 l=2
Xpos_inv pulse_pos pos_req vdd vss inv
Xpos_and pos_req sign_p pos_en vdd vss and2
Xsign_inv sign_n sign_p vdd vss inv
Xneg_and pulse_neg sign_n neg_en vdd vss and2
Xpos_en_inv pos_en pos_enb vdd vss inv
Xneg_en_inv neg_en neg_enb vdd vss inv
Xpos_gate psrc membrane pos_en pos_enb vdd vss transmission_gate
Xneg_gate nsrc membrane neg_en neg_enb vdd vss transmission_gate
.ends weight_inject_q716
